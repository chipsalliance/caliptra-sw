// SPDX-License-Identifier: Apache-2.0
//
// Licensed under the Apache License, Version 2.0 (the "License");
// you may not use this file except in compliance with the License.
// You may obtain a copy of the License at
//
// http://www.apache.org/licenses/LICENSE-2.0
//
// Unless required by applicable law or agreed to in writing, software
// distributed under the License is distributed on an "AS IS" BASIS,
// WITHOUT WARRANTIES OR CONDITIONS OF ANY KIND, either express or implied.
// See the License for the specific language governing permissions and
// limitations under the License.
//




addrmap recovery_reg {
    desc="address maps for recovery register interface space";


    addressing = regalign; // This is the default if not specified
    lsb0 = true; // lsb0 property is implicit/default. See docs for
                 // SystemRDL 2.0 sections 9.1 and 13.4

    default hw = na;
    signal {activelow; async; cpuif_reset; field_reset;} reset_b;
    signal {activelow; async;} hard_reset_b;
    signal {} recovery_ready;


    /* -----------------------
    * Register definitive definitions
    * ----------------------- */

    /* ---- RECOVERY Component Name ---- */
    reg {
        name = "Recovery register interface component name register type definition";
        desc = "Two 32-bit read-only registers representing of the name
                of RECOVERY component.";

        default sw = r;
        default hw = w;
        field {desc = "Name field";} NAME[32];

    } RECOVERY_NAME[2] @0x00000000;

    /* ---- RECOVERY Component Version and Capabilities ---- */
    reg {
        name = "Recovery register interface component version & capabilities register type definition";
        desc = "32-bit read-only registers representing of the version and capabilities
                of RECOVERY component.";

        default sw = r;
        default hw = w;
        field {desc = "Major Version field";} MAJOR_VERSION[8];
        field {desc = "Minor Version field";} MINOR_VERSION[8];
        field {desc = "Identification field";} IDENTIFICATION;
        field {desc = "Forced Recovery field";} FORCED_RECOVERY;
        field {desc = "Management reset field";} MGMT_RESET;
        field {desc = "Device Status field";} DEVICE_STATUS;
        field {desc = "Local C image field";} LOCAL_C_IMAGE;
        field {desc = "Push C image field";} PUSH_C_IMAGE;
        field {desc = "Interface Isolation field";} INTERFACE_ISOLATION;
        field {desc = "Hardware Status field";} HARDWARE_STATUS;
        field {desc = "Vendors Command field";} VENDORS_COMMAND;        
    } RECOVERY_VERSION_CAP @0x00000008;

    /* ---- RECOVERY Component memory space & timing ---- */
    reg {
        name = "Recovery register interface component memory space + timing";
        desc = "32-bit read-only registers representing of the number of recovery memory spaces and timing information.";

        default sw = r;
        default hw = w;
        field {desc = "Number of component memory spaces";} COMPONENT_MEMORY_SPACES[8];
        field {desc = "Maximum response time in ln(x) us";} MAX_RESPONSE_TIME[8];
        field {desc = "Heartbeat period in ln(x) us";} HEARTHBEAT_PERIOD[8];
    } RECOVERY_MEMORY_SPACE_TIMING @0x0000000c;

    /* ---- RECOVERY device id ---- */
    reg {
       name = "Recovery register interface device id";
       desc = "6 32-bit read-only registers respresenting the device id.
       Fist byte is type. Second bytes is string lenght. Last 22 bytes are ID.";

        default sw = r;
        default hw = w;
        field {desc = "ID of recovery register interface";} ID[32];
    } RECOVERY_DEVICE_ID[6] @0x00000010;

    /* ---- RECOVERY device status info ---- */
    reg {
        name = "Recovery register interface status info";
        desc = "32-biut read-only register representing the device status.";

        default sw = r;
        default hw = w;
        field {desc = "Device Status";} STATUS[8];
        field {desc = "Protocol Error";} ERROR[8];
        field {desc = "Recovery Reason";} RECOVERY_REASON[8];
    } DEVICE_INFO @0x00000028;

    /* ---- RECOVERY heartbeat ---- */
    reg {
        name = "Recovery register interface heartbeat";
        desc = "read-only register containing hearthbeat.";

        default sw = r;
        default hw = w;
        field {desc = "Heartbeat";} HEARTBEAT[16];
    } HEARTBEAT @0x0000002c;

    /* ---- RECOVERY device reset ---- */
    reg {
        name = "Recovery register interface reset control";
        desc = "RW reset control register.";

        default sw = rw;
        default hw = r;
        field {desc = "Reset control
                            No reset - 0x0
                            Reset Device - 0x1
                            Reset Management - 0x2
        ";} DEVICE_RESET[8];
        field { desc = "Forced reset
                            No Forced reset mode - 0x0
                            Recovery Mode - 0xf
        ";} FORCED_RESET[8];
        field { desc = "Activate recovery image
                            Do not activate - 0x0
                            Activate - 0xf
        ";} ACTIVATE_RECOVERY_IMAGE[8];
    } RESET_CONTROL @0x00000030;

    /* ---- RECOVERY control ---- */
    reg {
        name = "Recovery register interface control";
        desc = "RW recovery register interface control";

        default sw = rw;
        default hw = r;

        field { desc = "Content memory space"; } CMS[8];
        field { desc = "Image selection
                              No operation - 0
                              Recovery from CMS - 1
                              Recovery stored on device - 2
        "; }  IMAGE_SELECTION[8];
        field { desc = "Activate recovery image
                              Do not activate - 0
                              Activate - 0xf
        "; } ACTIVATE_RECOVERY_IMAGE[8];
    } RECOVERY_CONTROL @0x00000034;

    /* ---- RECOVERY status ---- */
    reg {
        name = "Recovery register interface recovery status";
        desc = "Read-only recovery status register";

        default sw = r;
        default hw = w;

        field { desc = "Recovery status:
                                 Not in recovery - 0
                                 Awaiting recovery image - 1
                                 Booting recovery image - 2
                                 Recovery succesfull - 3
                                 Recovery failed - 12
                                 Authenmtocation failed - 13
                                 Error entering recovery mode - 14
                                 Invalid component address space - 15
        "; } DEVICE_RECOVERY;
    } RECOVERY_STATUS @0x00000038;

    /* ---- RECOVERY Hardware status ---- */
    reg {
        name = "Recovery register interface hardware status";
        desc = "Read-only hardware status register";

        default sw = r;
        default hw = w;

        field { desc = "Hardware status
                                 Temperature critical - 0
                                 Hardware soft error - 1
                                 Hardware fatal error - 2
        "; } HW_STATUS[8];
        field { desc = "Vendor hardware status"; } VENDOR_HW_STATUS[8];
        field { desc = "Composite temperature
                                          0x00-0x7e: 0 to 126 C
                                          0x7f: 127 C or higher
                                          0x80: no temperature data, or data is older than 5 seconds
                                          0x81: temperature sensor failure
                                          0x82-0x83: reserved
                                          0xc4: -60 C or lower
                                          0xc5-0xff: -1 to -59 C (in twoʼs complement)
        "; } COMPOSITE_TEMP[16];
    } HW_STATUS @0x0000003C;

    /* ---- RECOVERY Indirect FIFO control ---- */
    reg {
        name = "Recover register interface indirect fifo control";
        desc = "Read Write register for controller the indirect FIFO.";

        default sw = rw;
        default hw = r;

        field { desc = "Component memory space";} CMS[8];
        field { desc = "Reset";} RESET[1];
    } INDIRECT_FIFO_CONTROL @0x00000040;

    /* ---- RECOVERY Indirect FIFO Image size ---- */
    reg {
        name = "Recovery register interface indirect FIFO";
        desc = "Read Write register for the indirect FIFO image size";

        default sw = rw;
        default hw = rw;

        field { desc = "Image size"; } IMAGE_SIZE[32];
    } INDIRECT_FIFO_IMAGE_SIZE @0x00000044;

    /* ---- RECOVERY Indirect FIFO status ---- */
    reg {
        name = "Recovery register interface indirect FIFO status";
        desc = "Read-Only register indicating indirect FIFO status";

        default sw = r;
        default hw = rw;

        field { desc = "FIFO empty"; } EMPTY[0:0];
        field { desc = "FIFO full"; } FULL[1:1];
        field { desc = "Region Type
                               Code space recovery - 0
                               Log with debug format - 1
                               Vendor defined write only region - 4
                               Vendor defined read only region - 5
                               Unsupported region - 7
        "; } REGION_TYPE[10:8];

    } INDIRECT_FIFO_STATUS @0x00000048;

    /* ---- RECOVERY write index ---- */
    reg {
        name = "Recovery register interface FIFO write index";
        desc = "Read-only register indicating write address in units of 4 bytes";

        default sw = r;
        default hw = rw;

        field { desc = "Write Index"; } WRITE_INDEX[32];
    } WRITE_INDEX @0x0000004c;

    /* ---- RECOVERY read index ---- */
    reg {
        name = "Recovery register interface FIFO read index";
        desc = "Read-only register indicating read address in units of 4 bytes";

        default sw = r;
        default hw = rw;

        field { desc = "Read Index"; } READ_INDEX[32];
    } READ_INDEX @0x00000050;

    /* ---- RECOVERY indirect size ---- */
    reg {
        name = "Recovery register interface FIFO size";
        desc = "Read-only register indicating the size of the indirect FIFO in units of 4 bytes";

        default sw = r;
        default hw = rw;

        field { desc = "Indirect FIFO size"; } INDIRECT_SIZE[32];
    } INDIRECT_SIZE @0x00000054;

    /* ---- RECOVERY max transfer size ---- */
    reg {
        name = "Recovery register interface FIFO max transfer size";
        desc = "Read-only register indicating the max size of a transfer to/from the FIFO in units of 4 bytes";

        default sw = r;
        default hw = rw;

        field { desc = "Max transfer size"; } MAX_TRANSFER_SIZE[32];
    } MAX_TRANSFER_SIZE @0x00000058;

    reg {
        name = "Recovery register interface FIFO data";
        desc = "Read-only register holding the FIFO data";

        default sw = r;
        default hw = rw;

        field { desc = "FIFO data"; } FIFO_DATA[32];
    } FIFO_DATA @0x0000006c;
};
